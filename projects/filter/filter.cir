* Target project placeholder; values are not measurements.
Vinput in 0 AC 1
R1 in out 1k
C1 out 0 100n
.ac dec 20 1 100000
.meas ac gain_db MAX 20*log10(abs(v(out)))
.meas ac bw_hz WHEN vdb(out)=gain_db-3
.end
